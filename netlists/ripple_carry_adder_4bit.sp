4-bit CMOS ripple-carry adder

.protec
.include '$PDK_DIR/ncsu_basekit/models/hspice/hspice_nom.include'
.include 'cmos_cells.inc'
.unprotec

.TEMP 25

.OPTION POST
+ PUTMEAS=0
+ MEASFAIL=0
+ PROBE=1
+ AUTOSTOP
+ RUNLVL = 6

.PARAM SupplyVoltage = 1.0V
.PARAM VDD = 1
Vn_VDD n_VDD 0 DC 'SupplyVoltage'
Vn_VSS n_VSS 0 DC 0.000000e+00

.SUBCKT HA_X A B S Co VDD VSS
X_NAND_X1 A B n1 VDD VSS NAND_X
X_NAND_X2 A n1 n2 VDD VSS NAND_X
X_NAND_X3 n1 B n3 VDD VSS NAND_X
X_NAND_X4 n2 n3 S VDD VSS NAND_X
X_INV_X1 n1 Co VDD VSS INV_X
.ENDS

.SUBCKT FA1_X A B Cin S Co VDD VSS
X_HA_X1 A B S1 C1 VDD VSS HA_X
X_HA_X2 S1 Cin S C2 VDD VSS HA_X
X_NOR_X1 C1 C2 C3 VDD VSS NOR_X
X_INV_X2 C3 Co VDD VSS INV_X
.ENDS

.SUBCKT Adder4_X A1 B1 A2 B2 A3 B3 A4 B4 S1 S2 S3 S4 C4 VDD VSS
X_FA1 A1 B1 VSS S1 C1 VDD VSS FA1_X
X_FA2 A2 B2 C1 S2 C2 VDD VSS FA1_X
X_FA3 A3 B3 C2 S3 C3 VDD VSS FA1_X
X_FA4 A4 B4 C3 S4 C4 VDD VSS FA1_X
.ENDS

VA1 A1 0 PULSE(0 VDD 1ns 20ps 20ps 20ns 40ns)
VA2 A2 0 PULSE(0 VDD 1ns 20ps 20ps 20ns 40ns)
VA3 A3 0 DC 0
VA4 A4 0 PULSE(0 VDD 1ns 20ps 20ps 20ns 40ns)

VB1 B1 0 DC 0
VB2 B2 0 PULSE(0 VDD 1ns 20ps 20ps 20ns 40ns)
VB3 B3 0 DC 0
VB4 B4 0 PULSE(0 VDD 1ns 20ps 20ps 20ns 40ns)

X_Adder4_X1 A1 B1 A2 B2 A3 B3 A4 B4 S1 S2 S3 S4 C4 n_VDD n_VSS Adder4_X

.TRAN 1p 8ns
.PROBE V(*) I(*)

.MEASURE TRAN P_AVG AVG PAR('-V(n_VDD)*I(Vn_VDD)')

.MEASURE TRAN P_MAX MAX PAR('-V(n_VDD)*I(Vn_VDD)')

.END
