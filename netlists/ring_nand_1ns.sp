55-stage CMOS NAND ring oscillator

.protec
.include '$PDK_DIR/ncsu_basekit/models/hspice/hspice_nom.include'
.include 'cmos_cells.inc'
.unprotec

.TEMP 25

.OPTION POST
+ PUTMEAS=0
+ MEASFAIL=0
+ PROBE=1
+ AUTOSTOP
+ RUNLVL = 6

.PARAM SupplyVoltage = 1.0V
.PARAM VDD = 1
Vn_VDD n_VDD 0 DC 'SupplyVoltage'
Vn_VSS n_VSS 0 DC 0.000000e+00

.SUBCKT NAND7 IN OUT VDD VSS
X_NAND1 IN VDD n1 VDD VSS NAND_X
X_NAND2 n1 VDD n2 VDD VSS NAND_X
X_NAND3 n2 VDD n3 VDD VSS NAND_X
X_NAND4 n3 VDD n4 VDD VSS NAND_X
X_NAND5 n4 VDD n5 VDD VSS NAND_X
X_NAND6 n5 VDD n6 VDD VSS NAND_X
X_NAND7 n6 VDD OUT VDD VSS NAND_X
.ENDS

.SUBCKT RO_NAND OUT VDD VSS
X_B1 OUT n1 VDD VSS NAND7
X_B2 n1 n2 VDD VSS NAND7
X_B3 n2 n3 VDD VSS NAND7
X_B4 n3 n4 VDD VSS NAND7
X_B5 n4 n5 VDD VSS NAND7
X_B6 n5 n6 VDD VSS NAND7
X_B7 n6 n7 VDD VSS NAND7
X_NAND50 n7 VDD n8 VDD VSS NAND_X
X_NAND51 n8 VDD n9 VDD VSS NAND_X
X_NAND52 n9 VDD n10 VDD VSS NAND_X
X_NAND53 n10 VDD n11 VDD VSS NAND_X
X_NAND54 n11 VDD n12 VDD VSS NAND_X
X_NAND55 n12 VDD OUT VDD VSS NAND_X
.ENDS

.IC V(n_A1) = 0

X_RO_NAND n_A1 n_VDD n_VSS RO_NAND

.TRAN 1p 8ns
.PROBE V(*) I(*)

.MEASURE TRAN t_oscill_period trig V(n_A1) val = 'SupplyVoltage/2' RISE=2
+ targ V(n_A1) val = 'SupplyVoltage/2' RISE=3

.END
