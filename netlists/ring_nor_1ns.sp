39-stage CMOS NOR ring oscillator

.protec
.include '$PDK_DIR/ncsu_basekit/models/hspice/hspice_nom.include'
.include 'cmos_cells.inc'
.unprotec

.TEMP 25

.OPTION POST
+ PUTMEAS=0
+ MEASFAIL=0
+ PROBE=1
+ AUTOSTOP
+ RUNLVL = 6

.PARAM SupplyVoltage = 1.0V
.PARAM VDD = 1
Vn_VDD n_VDD 0 DC 'SupplyVoltage'
Vn_VSS n_VSS 0 DC 0.000000e+00

.SUBCKT NOR7 IN OUT VDD VSS
X_NOR1 IN VSS n1 VDD VSS NOR_X
X_NOR2 n1 VSS n2 VDD VSS NOR_X
X_NOR3 n2 VSS n3 VDD VSS NOR_X
X_NOR4 n3 VSS n4 VDD VSS NOR_X
X_NOR5 n4 VSS n5 VDD VSS NOR_X
X_NOR6 n5 VSS n6 VDD VSS NOR_X
X_NOR7 n6 VSS OUT VDD VSS NOR_X
.ENDS

.SUBCKT RO_NOR OUT VDD VSS
X_B1 OUT n1 VDD VSS NOR7
X_B2 n1 n2 VDD VSS NOR7
X_B3 n2 n3 VDD VSS NOR7
X_B4 n3 n4 VDD VSS NOR7
X_B5 n4 n5 VDD VSS NOR7
X_NOR36 n5 VSS n6 VDD VSS NOR_X
X_NOR37 n6 VSS n7 VDD VSS NOR_X
X_NOR38 n7 VSS n8 VDD VSS NOR_X
X_NOR39 n8 VSS OUT VDD VSS NOR_X
.ENDS

.IC V(n_A1) = 0

X_RO_NOR n_A1 n_VDD n_VSS RO_NOR

.TRAN 1p 8ns
.PROBE V(*) I(*)

.MEASURE TRAN t_oscill_period trig V(n_A1) val = 'SupplyVoltage/2' RISE=2
+ targ V(n_A1) val = 'SupplyVoltage/2' RISE=3

.END
